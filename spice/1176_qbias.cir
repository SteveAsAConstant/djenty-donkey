* 1176LN Rev D: "Q" bias calibration (factory procedure: GR switched off, output drops 1.0 dB with the FET in)
.include 1176ln_revd.inc
.param ratio=4 att=0 outpos=1 atk=1 rel=1 gr=0 freq=2k amp=5m r30s=180k r86=35 tb=0 bdur=1e9 tstep=1e9 stepg=1 jn=1.3
.param q=0
* the calibrated trim against the FET pinched off (q = 1): 1.0 dB
.step param q list 0.30677 1.0
.tran 0 120m 0 2u
.save V(blu) V(red) V(g)
.meas tran vout RMS V(blu)-V(red) FROM 101m TO 119m
.meas tran vg AVG V(g) FROM 101m TO 119m
.end
