* 1176LN Rev D: static compression curves (2 kHz), factory test conditions: input and output pots full CW,
* attack full CW, release full CW, 600 ohm load. lev = source EMF (dBu); the level at the input terminals is measured.
.include 1176ln_revd.inc
.param att=0 outpos=1 atk=1 rel=1 gr=1 freq=2k q=0.30677 r30s=180k r86=35 tb=0 bdur=1e9 tstep=1e9 stepg=1 jn=1.3
.param ratio=4 lev=-40
.param amp={0.7746*sqrt(2)*10**(lev/20)}
.step param ratio list 1 2 3 4 5
.step param lev list -50 -45 -40 -35 -30 -25 -20 -15 -10
.tran 0 1.2 0 5u
.save V(blu) V(red) V(inp) V(ctrl)
.meas tran vin RMS V(inp) FROM 1.1 TO 1.2
.meas tran vout RMS V(blu)-V(red) FROM 1.1 TO 1.2
.meas tran vctrl AVG V(ctrl) FROM 1.1 TO 1.2
.end
