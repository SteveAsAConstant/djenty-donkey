* Ibanez TS9 Tube Screamer, from tonepad's "El Griton 2.2" TS-808 / TS-9 layout (rev Nov 28 2004), TS-9 values.
* Reference for Source/dsp/PrecisionDrive.h (OpAmpDrive::ts9). IC1 JRC4558: LTspice's universal op-amp (level 2) with datasheet values
* (Avol 100 dB, GBW 3 MHz, slew 1 V/us, output to within ~1.5 V of the 9 V rails); ideal=1 makes it near ideal
* (GBW 3 GHz, no slew limit, rail-to-rail) to separate the op-amp's part from the rest.
* The including file sets .param ideal (0 or 1). Params: d = DRIVE rotation, b = TONE wiper fraction from the R7 / C7 node end, vol = LEVEL
* rotation (DRIVE A taper (10^(2x)-1)/99, LEVEL B: linear), amp / freq = the input sine.
.lib UniversalOpAmp2.lib
.param d=0.5 vol=1
.param td={(pow(10,2*d)-1)/99} tv={vol}
.param gbw={if(ideal,3G,3Meg)} sr={if(ideal,1T,1Meg)} rl={if(ideal,0,1.5)}

VCC vcc 0 9
VREF vref 0 4.5
VIN src 0 SINE(0 {amp} {freq}) AC 1

* ---- input: R9 1M, C2 27n, R5 1k -> Q1 emitter follower (R1 510k bias, R10 10k) -> C3 1u, R2 10k ----
R9 src 0 2.2Meg
C2 src n2 27n
R5 n2 b1 1k
R1 vref b1 510k
Q1 vcc b1 e1 2N3904
R10 e1 0 10k
C3 e1 inp 1u
R2 vref inp 10k

* ---- IC1a clipper: feedback 1N914 x2, 51p, 51k + DRIVE A500k; leg 47n + 4k7 ----
XU1 inp nneg vcc 0 o1 level2 Avol=100k GBW={gbw} Slew={sr} Rail={rl}
D1 nneg o1 1N4148
D2 o1 nneg 1N4148
C8 o1 nneg 51p
R15 o1 nrf 51k
RDRV nrf nneg {500k*td+1}
CATT nneg nbus 47n
R16 nbus vref 4.7k

* ---- 1k -> 220n to ground, 10k to Vref -> IC1b tone stage (TONE B20k, 220n + 220R, feedback 1k) ----
R7 o1 nt 1k
C7 nt 0 220n
R3 vref nt 10k
XU2 nt nm vcc 0 o2 level2 Avol=100k GBW={gbw} Slew={sr} Rail={rl}
R8 o2 nm 1k
RBa nt nw {20k*b+1}
RBb nw nm {20k*(1-b)+1}
C5 nw nc5 220n
R12 nc5 0 220

* ---- 1u, 1k -> LEVEL A100k (to Vref) -> 100n -> Q2 emitter follower -> 470R, 10u -> out (100k) ----
C1 o2 nc1 1u
R4 nc1 nvt 1k
RVa nvt nvw {100k*(1-tv)+1}
RVb nvw vref {100k*tv+1}
C4 nvw b2 100n
R6 vref b2 510k
Q2 vcc b2 e2 2N3904
R13 e2 0 10k
R11 e2 nc6 470
C6 nc6 out 10u
R14 out 0 100k

.model 2N3904 NPN(IS=1E-14 VAF=100 Bf=300 IKF=0.4 XTB=1.5 BR=4 CJC=4E-12 CJE=8E-12 RB=20 RC=0.1 RE=0.1 TR=250E-9 TF=350E-12 ITF=1 VTF=2 XTF=3)
.model 1N4148 D(Is=2.52n Rs=.568 N=1.752 Cjo=4p M=.4 tt=20n)
.end
