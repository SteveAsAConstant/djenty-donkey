* 1176LN Rev D: R86 (LN trim) for minimum distortion in compression: 1 kHz, 4:1, ~8 dB GR, slowest release
.include 1176ln_revd.inc
.param att=0 outpos=0.4 atk=1 rel=0 gr=1 freq=1k q=0.30677 r30s=180k ratio=1 tb=0 bdur=1e9 tstep=1e9 stepg=1 jn=1.3
.param lev=-10 r86=50
.param amp={0.7746*sqrt(2)*10**(lev/20)}
.step param r86 list 0 20 30 35 40 50 70
.tran 0 0.6 0 2u
.save V(vdiff) V(blu) V(red) V(ctrl) V(inp) V(o)
Bdiff vdiff 0 V=V(blu)-V(red)
.four 1k 9 1 V(vdiff)
.meas tran vout RMS V(blu)-V(red) FROM 0.55 TO 0.6
.meas tran vo RMS V(o) FROM 0.55 TO 0.6
.end
