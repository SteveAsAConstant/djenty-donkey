* 1176LN Rev D: output stage bias (R30* select)
.include 1176ln_revd.inc
.param ratio=4 att=0 outpos=1 atk=1 rel=1 gr=0 freq=2k amp=0 q=0.30677 r86=35 tb=0 bdur=1e9 tstep=1e9 stepg=1 jn=1.3
.param r30s=180k
.step param r30s list 180k 200k 220k 270k 1G
.tran 0 2m 1m 10u
.meas tran ic6 AVG Ic(Q6)
.meas tran ve6 AVG V(e6)
.meas tran vc4 AVG V(c4)
.meas tran itot AVG -I(V30)
.end
