* 5150 power section: V3A recovery -> LTP phase inverter -> 4x 6L6GC -> OT -> 4x12 speaker, NFB with
* Presence / Resonance. Same circuit as Source/dsp/PowerAmp5150.h (reference for the C++ model).
.include 12AX7.inc
.include 6L6GC.inc

.param run=1
.param pres=table(run,1,0.0,2,1.0,3,0.0,4,0.5)
.param res=table(run,1,0.0,2,0.0,3,1.0,4,0.5)
.param freq=1k amp=0.02
.param np={sqrt(2100/8)}
.param Ls={30/(np*np)}
.param Lh={Ls*(np/2)*(np/2)}

* ---- supplies ----
V0 v0 0 500
Dr v0 vr DR
Rsup vr bplus 60
Cres bplus 0 100u
Rscr bplus scr 400
Cscr scr 0 47u
B3 v3 0 V=0.86*V(bplus)
VB1 vb320 0 320
Vbias bias 0 -54.01
.model DR D(Ron=0.01 Roff=1G Vfwd=0)

* ---- input at the master pot wiper -> V3A ----
Vin in 0 SINE(0 {amp} {freq})
Rsrc in n1 100k
C11 n1 na 47n
R26 na 0 1Meg
Rs3 na g3 1k
X3A p3 g3 k3 12AX7
R5 vb320 p3 68k
R14 k3 0 3.3k
C61 k3 0 4.7n

* ---- LTP phase inverter ----
C49 p3 p1 22n
R50 p1 q 1Meg
R48 p1 gb 100k
R53 ga q 1Meg
C31 ga l 47n
R52 k q 470
R51 q l 10k
R57 l 0 4.7k
R46 v3 pb 82k
R58 v3 pa 100k
X4B pb gb k 12AX7
X4A pa ga k 12AX7

* ---- NFB: Resonance (VR8 1M log) and Presence (VR9 10k) ----
R56 s m 39k
C12 m l 6.8n
RVR8 m l {(pow(10,2*res)-1)/99*1Meg+100}
RVR9 l pr {(1-pres)*10k+10}
C8 pr 0 0.1u

* ---- output grids ----
C29 pb c1 47n
R55 c1 bias 220k
R206 c1 g1 2.2k
C28 pa c2 47n
R54 c2 bias 220k
R202 c2 g2 2.2k

* ---- 2 x 2 x 6L6GC ----
X5 o1 g1 0 scr 6L6GC
X7 o1 g1 0 scr 6L6GC
X6 o2 g2 0 scr 6L6GC
X8 o2 g2 0 scr 6L6GC
D200 0 o1 DF
D201 0 o2 DF
.model DF D(IS=1e-9 RS=1)

* ---- output transformer (ideal coupling + magnetizing inductance) ----
L1 o1 bplus {Lh}
L2 bplus o2 {Lh}
L3 s 0 {Ls}
K1 L1 L2 L3 1
Cw o1 o2 2.5n

* ---- 4x12 speaker impedance ----
Re s sp1 6
Le sp1 sp2 0.5m
Rle sp1 sp2 30
Rm sp2 0 8
Lm sp2 0 20.7m
Cm sp2 0 122u

.tran 0 0.25 0 4u
.step param run list 1 2 3 4
.step param freq list 50 100 200 500 1000 2000 5000 10000
.meas tran vpk PP V(s) FROM 0.2 TO 0.25
.meas tran bplus_v AVG V(bplus) FROM 0.2 TO 0.25
.end
