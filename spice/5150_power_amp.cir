* 5150 power section: V3A recovery -> LTP phase inverter -> 4x 6L6GC -> OT -> 4x12 speaker, NFB with
* Presence / Resonance. Same circuit as Source/dsp/PowerAmp5150.h (reference for the C++ model).
.include 12AX7.inc
.include 6L6GC.inc

.param run=1
.param pres=table(run,1,0.0,2,1.0,3,0.0,4,0.5)
.param res=table(run,1,0.0,2,0.0,3,1.0,4,0.5)
.param freq=1k amp=0.02
.param np={sqrt(2100/8)}
.param Ls={30/(np*np)}
.param Lh={Ls*(np/2)*(np/2)}

* ---- supplies ----
* power transformer HV winding (350 VAC at 600 mA: 374.5 V unloaded, 41 ohm, 60 Hz) -> bridge CR8-CR11 1N4007
Vsec ta tb SINE(0 {374.5*sqrt(2)} 60)
Rw ta ta1 41
D8 tb bplus D1N4007
D9 ta1 bplus D1N4007
D10 0 ta1 D1N4007
D11 0 tb D1N4007
Rbl1 bplus 0 440k
* factory supply chain (schematic sheet 2): PLATE -> R210 -> SCREEN -> R59 -> V3+ (PI) -> R60 -> V2+ (V3A, V3B,
* preamp V2B V5B V5A) -> R61 -> V1+ (preamp V1A V1B V2A); the preamp as its idle currents, V3B as a real tube
Cres bplus 0 165u
Rscr bplus scr 400
Cscr scr 0 50u
Rbl2 scr 0 440k
R59 scr v3 4k
C36 v3 0 47u
R60 v3 v2 22k
C37 v2 0 22u
R61 v2 v1 10k
C33 v1 0 22u
Ipre2 v2 0 2.19m
Ipre1 v1 0 1.65m
X3B v2 g3b k3b 12AX7
R80 k3b j3b 1k
R16 j3b 0 100k
R79 g3b j3b 1Meg
Vbias bias 0 -53.26
.model D1N4007 D(Is=7.02767n Rs=0.0341512 N=1.80803 Cjo=10p M=0.3 Bv=1000 tt=4.32u)
* start the rails at their idle values (the mains sine starts at 0 V)
.ic V(bplus)=487.7 V(scr)=479.6 V(v3)=445 V(v2)=317.5 V(v1)=301.2

* ---- input at the master pot wiper -> V3A ----
Vin in 0 SINE(0 {amp} {freq})
Rsrc in n1 100k
C11 n1 na 47n
R26 na 0 1Meg
Rs3 na g3 1k
X3A p3 g3 k3 12AX7
R5 v2 p3 68k
R14 k3 0 3.3k
C61 k3 0 4.7n

* ---- LTP phase inverter ----
C49 p3 p1 22n
R50 p1 q 1Meg
R48 p1 gb 100k
R53 ga q 1Meg
C31 ga l 47n
R52 k q 470
R51 q l 10k
R57 l 0 4.7k
R46 v3 pb 82k
R58 v3 pa 100k
X4B pb gb k 12AX7
X4A pa ga k 12AX7

* ---- NFB: Resonance (VR8 1M POT0752 "5% A": the pre-gain pots' law) and Presence (VR9 10k log, wiper tied to C8 || C62), C30 to the tail ----
R56 s m 39k
C12 m y 6.8n
RVR8 m y {(pow(10,2.65*res)-1)/(pow(10,2.65)-1)*1Meg+100}
C30 y l 22u
RVR9 y pr {(1-(pow(10,2*pres)-1)/99)*10k+10}
C8 pr 0 0.1u
C62 pr 0 0.033u

* ---- output grids ----
C29 pb c1 47n
R55 c1 bias 220k
C202 c1 0 100p
R206 c1 g1 2.2k
C28 pa c2 47n
R54 c2 bias 220k
C201 c2 0 100p
R202 c2 g2 2.2k
* 6L6GC interelectrode capacitances (datasheet), two tubes per side: input 10p, grid-to-plate 0.6p each
Cin1 g1 0 20p
Cgp1 g1 o1 1.2p
Cin2 g2 0 20p
Cgp2 g2 o2 1.2p

* ---- 2 x 2 x 6L6GC ----
X5 o1 g1 0 s5 6L6GC
X7 o1 g1 0 s7 6L6GC
X6 o2 g2 0 s6 6L6GC
X8 o2 g2 0 s8 6L6GC
* R207 / R209 / R203 / R205: each tube's 100 ohm screen resistor
R207 scr s5 100
R209 scr s7 100
R203 scr s6 100
R205 scr s8 100
D200 0 o1 DF
D201 0 o2 DF
.model DF D(IS=1e-9 RS=1)

* ---- output transformer (ideal coupling + magnetizing inductance) ----
L1 o1 bplus {Lh}
L2 bplus o2 {Lh}
L3 s 0 {Ls}
K1 L1 L2 L3 1
Cw o1 o2 2.5n

* ---- 4x12 of Vintage 30s: Re 7.3, voice coil 0.7 mH || 6, motional Res || Lces || Cmes (fc 85 Hz, Qec 0.884, Qmc 2) ----
Re s sp1 7.3
Le sp1 sp2 0.7m
Rle sp1 sp2 6
Rm sp2 0 16.516
Lm sp2 0 15.462m
Cm sp2 0 226.74u

.tran 0 0.25 0 4u
.step param run list 1 2 3 4
.step param freq list 50 100 200 500 1000 2000 5000 10000
.meas tran vpk PP V(s) FROM 0.2 TO 0.25
.meas tran bplus_v AVG V(bplus) FROM 0.2 TO 0.25
.end
